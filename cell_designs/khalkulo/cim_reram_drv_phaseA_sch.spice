* Reference SPICE for cim_reram_drv_phaseA — per-array wrapper around
* the source-rail MUX. One instance per array (D16, 1× per array per
* Track 06 Phase A architecture correction). Just a thin pass-through
* that re-exposes the srcmux's ports at the wrapper boundary.
*
* Phase A note: VSL_DAC_IN (the V_SL DAC output bus, live in Phase B1)
* is currently stubbed to VDDA1 inside the srcmux — both pmos25.S pins
* share the VDDA1 net in the layout. When Phase B1 lands the DAC,
* the SETRR-side pmos25 source/body will move to a separate net and
* this wrapper will gain VSL_DAC_IN as a 4th rail port.

.include cim_reram_drv_phaseA_srcmux_sch.spice

.subckt cim_reram_drv_phaseA
+ VDDA1 VDD VSS SRC_RAIL
+ pulse_req_1v8 pulse_kind_form_1v8 pulse_kind_setrr_1v8

XSRCMUX VDDA1 SRC_RAIL
+ pulse_req_1v8 pulse_kind_form_1v8 pulse_kind_setrr_1v8
+ VDD VSS
+ cim_reram_drv_phaseA_srcmux

.ends cim_reram_drv_phaseA
