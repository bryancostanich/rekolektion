* Reference SPICE for cim_reram_drv_phaseA_srcmux (extracted from
* khalkulo/source/cell_designs/reram_drv/cim_reram_drv_phaseA_sch.spice).
* Hierarchical: includes the nand2_inv_lv and lshift_1v8_to_3v3
* subckt definitions so netgen can match them against the layout's
* SRef'd composite cells (which also extract as hierarchical
* subckts since Magic preserves cell hierarchy).

.include nand2_inv_lv_sch.spice
.include lshift_1v8_to_3v3_sch.spice

.subckt cim_reram_drv_phaseA_srcmux
+ VDDA1 SRC_RAIL
+ pulse_req_1v8 pulse_kind_form_1v8 pulse_kind_setrr_1v8
+ VDD VSS

* FORM branch
XAND_FORM    pulse_req_1v8 pulse_kind_form_1v8  form_active_1v8 VDD VDDA1 VSS nand2_inv_lv
XLSH_FORM    form_active_1v8 lsh_form_n lsh_form VDD VDDA1 VSS lshift_1v8_to_3v3
XPMOS_FORM   SRC_RAIL lsh_form VDDA1 VDDA1 sky130_fd_pr__pfet_g5v0d10v5 w=250.0 l=0.5 nf=10

* SETRR branch
XAND_SETRR   pulse_req_1v8 pulse_kind_setrr_1v8 setrr_active_1v8 VDD VDDA1 VSS nand2_inv_lv
XLSH_SETRR   setrr_active_1v8 lsh_setrr_n lsh_setrr VDD VDDA1 VSS lshift_1v8_to_3v3
XPMOS_SETRR  SRC_RAIL lsh_setrr VDDA1 VDDA1 sky130_fd_pr__pfet_g5v0d10v5 w=250.0 l=0.5 nf=10

* SRC_RAIL discharge — pulls SRC_RAIL to VSS when pulse_req is low,
* so the rail doesn't float at ~3 V after a pulse and breach the
* access FET's V_DS spec during the exit transient. Verified across
* 9 PVT in phaseA_form_tb (worst case ss/85 °C: V_DS = 0.40 V).
* Inverter generates pulse_req_n in the 1.8 V domain.
XINV_PR_P pulse_req_n pulse_req_1v8 VDD VDD sky130_fd_pr__pfet_01v8 w=2.0 l=0.15
XINV_PR_N pulse_req_n pulse_req_1v8 VSS VSS sky130_fd_pr__nfet_01v8 w=1.0 l=0.15
* 5 V NFET pulls SRC_RAIL → VSS while pulse_req_n is high (idle/exit).
XDISCHARGE SRC_RAIL pulse_req_n VSS VSS sky130_fd_pr__nfet_g5v0d10v5 w=2.0 l=0.5

.ends cim_reram_drv_phaseA_srcmux
