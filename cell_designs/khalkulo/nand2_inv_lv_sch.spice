* Reference SPICE for nand2_inv_lv (extracted from
* khalkulo/source/cell_designs/reram_drv/cim_reram_drv_phaseA_sch.spice).
*
* The PFET bulk is tied to VDDA1 (NOT VDD) so this cell's nwell can
* merge with the surrounding pmos25/lshift nwell in the srcmux
* parent — saves the ~1.27 µm nwell.2a gap that a VDD-biased nwell
* would otherwise require around every nand2 instance. Vbs on each
* PFET is +1.5 V reverse-bias (VDDA1=3.3 minus VDD=1.8), which is
* electrically benign for a 1.8 V LV PFET.

.subckt nand2_inv_lv A B Y VDD VDDA1 VSS

* NAND2: nand_out = NOT(A AND B).
XNAND_PA nand_out A VDD     VDDA1 sky130_fd_pr__pfet_01v8 w=2.0 l=0.15
XNAND_PB nand_out B VDD     VDDA1 sky130_fd_pr__pfet_01v8 w=2.0 l=0.15
XNAND_NA nand_out A nand_mid VSS  sky130_fd_pr__nfet_01v8 w=1.0 l=0.15
XNAND_NB nand_mid B VSS     VSS   sky130_fd_pr__nfet_01v8 w=1.0 l=0.15

* INV: Y = NOT(nand_out) = A AND B.
XINV_P Y nand_out VDD VDDA1 sky130_fd_pr__pfet_01v8 w=2.0 l=0.15
XINV_N Y nand_out VSS VSS   sky130_fd_pr__nfet_01v8 w=1.0 l=0.15

.ends nand2_inv_lv
