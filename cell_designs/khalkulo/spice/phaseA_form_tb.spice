* Phase A FORM pulse transient testbench
*
* Verifies the cim_reram_drv_phaseA wrapper drives SRC_RAIL correctly
* during a FORM pulse and does NOT breach the access FET's V_DS spec
* during entry / steady / exit transients.
*
* Control sequence follows forming_fsm_contract.md handshake:
*   t = 100 ns  →  pulse_kind_form goes high (decode/setup)
*   t = 200 ns  →  WL ramps to 1.2 V on selected row (cycle 1 settle)
*   t = 300 ns  →  pulse_req goes high (cycle 2 — pulse start)
*   t = 1300 ns →  pulse_req goes low (1 µs pulse per D9)
*   t = 1400 ns →  WL drops back to 0
*   t = 1500 ns →  pulse_kind_form goes low
*
* WL-on-first / WL-off-last ordering protects the access FET's V_DS
* during entry and exit transients.
*
* Phase A driver design WITHOUT a SRC_RAIL discharge path leaves
* SRC_RAIL floating at ~3 V after the pulse — V_DS spec breaches when
* WL falls. This testbench includes a PROPOSED FIX: a 5 V NFET from
* SRC_RAIL to VSS, gated by ~pulse_req. Once verified across 9-PVT,
* the discharge FET will be integrated into the srcmux layout.

.title Phase A FORM pulse __CORNER__ __TEMP__C

.lib /Users/bryancostanich/.volare/sky130B/libs.tech/ngspice/sky130.lib.spice __CORNER__
.include /Users/bryancostanich/git_repos/bryan_costanich/rekolektion/cell_designs/khalkulo/spice/cim_reram_drv_phaseA_srcmux_extracted.spice

.option temp = __TEMP__

* === Supplies (ramped to let cross-coupled latch settle to safe state) ===
V_VDDA1 VDDA1 0 PWL(0 0 1n 0 50n 3.30)
V_VDD   VDD   0 PWL(0 0 1n 0 50n 1.80)
V_VSS   VSS   0 DC 0

* === DUT ===
* Port order (from extracted subckt header): VDD VDDA1 VSS SRC_RAIL pulse_req_1v8 pulse_kind_form_1v8 pulse_kind_setrr_1v8
X_DUT VDD VDDA1 VSS SRC_RAIL pulse_req_1v8 pulse_kind_form_1v8 pulse_kind_setrr_1v8
+ cim_reram_drv_phaseA_srcmux

* === Control inputs ===
V_PK_FORM  pulse_kind_form_1v8  0 PWL(0 0 99n 0 100n 1.8 1500n 1.8 1501n 0)
V_PK_SETRR pulse_kind_setrr_1v8 0 DC 0
V_PR       pulse_req_1v8        0 PWL(0 0 299n 0 300n 1.8 1300n 1.8 1301n 0)

* === Victim cell (instrumented for V_DS) ===
V_WL_VICTIM WL_victim 0 PWL(0 0 199n 0 200n 1.2 1400n 1.2 1401n 0)
V_BL_VICTIM BL_victim 0 DC 0
* RRAM post-forming = ~100 kΩ LRS (the discharge path during exit).
R_RRAM_VICTIM SRC_RAIL BE_victim 100k
* Access FET: sky130 1.8 V NFET W=1.5 µm L=0.5 µm per Track 04 cell.
XM_FET_VICTIM BE_victim WL_victim BL_victim 0 sky130_fd_pr__nfet_01v8 w=1.5 l=0.5

* === Lumped 255 inhibited cells on the same SL (parasitic cap only) ===
C_SL_LUMPED SRC_RAIL 0 5p

* === SRC_RAIL discharge is now integrated inside the srcmux DUT. ===
* Previously this TB ran the discharge externally via a behavioral
* inverter + standalone NFET; the layout now carries both, so the
* DUT instance covers the full path on its own.

* === Analysis ===
.tran 1n 2u

.control
  run

  * Rise time (10% → 90% of VDDA1) during ENTRY transient
  meas tran t_rise_start WHEN v(SRC_RAIL)=0.33 RISE=1
  meas tran t_rise_end   WHEN v(SRC_RAIL)=2.97 RISE=1
  let t_rise = t_rise_end - t_rise_start

  * Steady-state SRC_RAIL (mid-pulse)
  meas tran v_src_steady FIND v(SRC_RAIL) AT=800n

  * Fall time (90% → 10%) during EXIT transient
  meas tran t_fall_start WHEN v(SRC_RAIL)=2.97 FALL=1
  meas tran t_fall_end   WHEN v(SRC_RAIL)=0.33 FALL=1
  let t_fall = t_fall_end - t_fall_start

  * SRC_RAIL at the moment WL drops (1.4 µs) — must be < 1.95 V for safety
  meas tran v_src_wl_fall FIND v(SRC_RAIL) AT=1.4u

  * Peak V_DS on victim access FET across entire window.
  * V_DS = V(BE) - V(BL) = V(BE_victim). Must stay below 1.95 V.
  meas tran v_ds_peak MAX v(BE_victim) FROM=100n TO=2u

  print t_rise t_fall v_src_steady v_src_wl_fall v_ds_peak
.endc

.end
