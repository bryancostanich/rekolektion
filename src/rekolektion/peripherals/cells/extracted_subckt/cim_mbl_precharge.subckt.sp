* NGSPICE file created from cim_mbl_precharge.ext - technology: sky130B

.subckt cim_mbl_precharge MBL_PRE VREF MBL
X0 VREF MBL_PRE MBL w_24_24# sky130_fd_pr__pfet_01v8 ad=0.2772 pd=2.34 as=0.2772 ps=2.34 w=0.84 l=0.15
.ends
