* NGSPICE file created from sky130_fd_bd_sram__openram_dff.ext - technology: sky130B

.subckt sky130_fd_bd_sram__openram_dff D CLK Q VDD GND
X0 VDD a_28_102# a_389_712# VDD sky130_fd_pr__pfet_01v8 ad=0.42 pd=3.28 as=0.315 ps=3.21 w=3 l=0.15
X1 a_47_611# CLK a_197_712# VDD sky130_fd_pr__pfet_01v8 ad=0.675 pd=3.45 as=0.315 ps=3.21 w=3 l=0.15
X2 a_239_76# CLK VDD VDD sky130_fd_pr__pfet_01v8 ad=0.795 pd=6.53 as=0.42 ps=3.28 w=3 l=0.15
X3 a_197_712# D VDD VDD sky130_fd_pr__pfet_01v8 ad=0.315 pd=3.21 as=0.42 ps=3.28 w=3 l=0.15
X4 QN CLK a_547_102# GND sky130_fd_pr__nfet_01v8 ad=0.225 pd=1.45 as=0.105 ps=1.21 w=1 l=0.15
X5 GND Q a_739_102# GND sky130_fd_pr__nfet_01v8 ad=0.14 pd=1.28 as=0.105 ps=1.21 w=1 l=0.15
X6 Q QN GND GND sky130_fd_pr__nfet_01v8 ad=0.265 pd=2.53 as=0.265 ps=2.53 w=1 l=0.15
X7 a_389_712# a_239_76# a_47_611# VDD sky130_fd_pr__pfet_01v8 ad=0.315 pd=3.21 as=0.675 ps=3.45 w=3 l=0.15
X8 VDD a_47_611# a_28_102# VDD sky130_fd_pr__pfet_01v8 ad=0.42 pd=3.28 as=0.795 ps=6.53 w=3 l=0.15
X9 a_547_712# a_28_102# VDD VDD sky130_fd_pr__pfet_01v8 ad=0.315 pd=3.21 as=0.42 ps=3.28 w=3 l=0.15
X10 a_739_712# CLK QN VDD sky130_fd_pr__pfet_01v8 ad=0.315 pd=3.21 as=0.675 ps=3.45 w=3 l=0.15
X11 GND a_28_102# a_389_102# GND sky130_fd_pr__nfet_01v8 ad=0.14 pd=1.28 as=0.105 ps=1.21 w=1 l=0.15
X12 a_47_611# a_239_76# a_197_102# GND sky130_fd_pr__nfet_01v8 ad=0.225 pd=1.45 as=0.105 ps=1.21 w=1 l=0.15
X13 a_239_76# CLK GND GND sky130_fd_pr__nfet_01v8 ad=0.265 pd=2.53 as=0.14 ps=1.28 w=1 l=0.15
X14 a_197_102# D GND GND sky130_fd_pr__nfet_01v8 ad=0.105 pd=1.21 as=0.14 ps=1.28 w=1 l=0.15
X15 a_389_102# CLK a_47_611# GND sky130_fd_pr__nfet_01v8 ad=0.105 pd=1.21 as=0.225 ps=1.45 w=1 l=0.15
X16 GND a_47_611# a_28_102# GND sky130_fd_pr__nfet_01v8 ad=0.14 pd=1.28 as=0.265 ps=2.53 w=1 l=0.15
X17 a_547_102# a_28_102# GND GND sky130_fd_pr__nfet_01v8 ad=0.105 pd=1.21 as=0.14 ps=1.28 w=1 l=0.15
X18 a_739_102# a_239_76# QN GND sky130_fd_pr__nfet_01v8 ad=0.105 pd=1.21 as=0.225 ps=1.45 w=1 l=0.15
X19 VDD Q a_739_712# VDD sky130_fd_pr__pfet_01v8 ad=0.42 pd=3.28 as=0.315 ps=3.21 w=3 l=0.15
X20 QN a_239_76# a_547_712# VDD sky130_fd_pr__pfet_01v8 ad=0.675 pd=3.45 as=0.315 ps=3.21 w=3 l=0.15
X21 Q QN VDD VDD sky130_fd_pr__pfet_01v8 ad=0.795 pd=6.53 as=0.795 ps=6.53 w=3 l=0.15
.ends
