* NGSPICE file created from sky130_fd_bd_sram__sram_sp_cell_opt1.ext - technology: sky130B

.subckt sky130_fd_bd_sram__sram_sp_cell_opt1 BL BR WL VGND VNB VPB VPWR GND VDD
X0 a_38_292# WL a_38_212# VNB sky130_fd_pr__nfet_01v8 ad=0.0168 pd=0.52 as=0.02187 ps=0.46 w=0.14 l=0.15
X1 a_174_54# a_0_24# a_174_54# VPB sky130_fd_pr__pfet_01v8_hvt ad=0.0175 pd=0.39 as=0.035 ps=0.78 w=0.14 l=0.025
X2 a_174_212# a_16_182# a_174_134# VPB sky130_fd_pr__pfet_01v8_hvt ad=0.0175 pd=0.39 as=0.032 ps=0.57 w=0.14 l=0.15
X3 a_174_134# a_16_104# a_174_54# VPB sky130_fd_pr__pfet_01v8_hvt ad=0.032 pd=0.57 as=0.0175 ps=0.39 w=0.14 l=0.15
X4 a_174_212# WL a_174_212# VPB sky130_fd_pr__pfet_01v8_hvt ad=0.0175 pd=0.39 as=0.035 ps=0.78 w=0.14 l=0.025
X5 a_38_212# a_16_182# a_0_142# VNB sky130_fd_pr__nfet_01v8 ad=0.02187 pd=0.46 as=0.0404 ps=0.64 w=0.21 l=0.15
X6 a_38_54# a_0_24# a_38_0# VNB sky130_fd_pr__nfet_01v8 ad=0.02187 pd=0.46 as=0.0168 ps=0.52 w=0.14 l=0.15
X7 a_0_142# a_16_104# a_38_54# VNB sky130_fd_pr__nfet_01v8 ad=0.0404 pd=0.64 as=0.02187 ps=0.46 w=0.21 l=0.15
.ends
